{
  name: "student_audio_init"
  clock_primary: "clk_i"
  bus_device: "tlul"
  regwidth: "32"
  registers: [
    {
      name: "Start_Audio_Init"
      desc: "Starts the initialization of the audio codec"
      swaccess: "wo"
      hwaccess: "hro"
      fields: [
        {bits: "0", name: "start", desc: "Bit to start audio configuration", resval: "0x0"}
      ]
    },
    {
      name: "Audio_Init_Done"
      desc: "Signals that audio initialization is done"
      swaccess: "ro"
      hwaccess: "hwo"
      fields: [
        {bits: "0", name: "done", desc: "Bit signals that configuration is done", resval: "0x0"}
      ]
    }
  ]
}
