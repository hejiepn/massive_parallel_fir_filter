{
  name: "student_filter_module"
  clock_primary: "sys_clk"
  bus_device: "tlul"
  regwidth: "32"
  registers: [
	{
      name: "FIR_enable"
      desc: "enables filter module otherwise data will be just passed"
      swaccess: "wo"
      hwaccess: "hro"
      fields: [
        {bits: "0", name: "enable", desc: "0: disabled, 1:enabled"}
      ]
    }
    {
      name: "mode"
      desc: "sets effect mode of filter module"
      swaccess: "wo"
      hwaccess: "hro"
      fields: [
        {bits: "8:0", name: "mode", desc: "effect mode"}
      ]
    }
	{
      name: "FIR_coeff_addr"
      desc: "memory address of coefficient"
      swaccess: "wo"
      hwaccess: "hro"
      fields: [
        {bits: "31:0", name: "coefficient memory address", desc: "show memory address of coefficient"}
      ]
    }
  ]
}