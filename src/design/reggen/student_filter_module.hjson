{
  name: "student_filter_module"
  clock_primary: "sys_clk"
  bus_device: "tlul"
  regwidth: "32"
  registers: [
	{
      name: "Debug Enable"
      desc: "enables debug fir filter module to test component single handly"
      swaccess: "wo"
      hwaccess: "hro"
	  hwqe : "true"
      fields: [
        {bits: "0", name: "Debug enable", desc: "0: disabled, 1:enabled"}
      ]
    }
    {
      name: "mode"
      desc: "sets effect mode of filter module"
      swaccess: "wo"
      hwaccess: "hro"
	  hwqe : "true"
      fields: [
        {bits: "8:0", name: "mode", desc: "effect mode"}
      ]
    }
  ]
}