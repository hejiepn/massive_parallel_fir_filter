{
  name: "student_filter_module"
  clock_primary: "sys_clk"
  bus_device: "tlul"
  regwidth: "32"
  registers: [
	{
      name: "Debug Enable"
      desc: "enables debug fir filter module to test component single handly"
      swaccess: "wo"
      hwaccess: "hro"
	  hwqe : "true"
      fields: [
        {bits: "0", name: "Debug enable", desc: "0: disabled, 1:enabled"}
      ]
    }
    {
      name: "Coef In"
      desc: "hardware read coefficients from register"
      swaccess: "wo"
      hwaccess: "hro"
	  hwqe : "true"
      fields: [
        {bits: "15:0", name: "Coef In", desc: "load coefficients"}
      ]
    }
    {
      name: "FIR Out A"
      desc: "hardware writes high 32 bits fir results to register"
      swaccess: "ro"
      hwaccess: "hwo"
	  hwqe : "true"
      fields: [
        {bits: "31:0", name: "FIR Out A", desc: "fir results"}
      ]
    }
    {
      name: "FIR Out B"
      desc: "hardware writes low 32 bits fir results to register"
      swaccess: "ro"
      hwaccess: "hwo"
	  hwqe : "true"
      fields: [
        {bits: "31:0", name: "FIR Out B", desc: "fir results"}
      ]
    }
    {
      name: "Samples In"
      desc: "register writes samples in hardware"
      swaccess: "wo"
      hwaccess: "hro"
	  hwqe : "true"
      fields: [
        {bits: "15:0", name: "Samples In", desc: "load samples"}
      ]
    }
  ]
}