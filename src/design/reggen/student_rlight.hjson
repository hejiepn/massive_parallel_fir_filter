{
  name: "student_rlight"
  clock_primary: "clk_i"
  bus_device: "tlul"
  regwidth: "32"
  registers: [
    {
      name: "Led_pattern"
      desc: "Contains the Pattern for the Running Light"
      swaccess: "rw"
      hwaccess: "hro"
      fields: [
        {bits: "7:0", name: "led_pattern", desc: "bit pattern", resval: "0x18"}
      ]
    },
    {
      name: "Delay"
      desc: "Controls the Speed of the Running light (in CC)"
      swaccess: "rw"
      hwaccess: "hro"
      fields: [
        {bits: "31:0", name: "Delay", desc: "Delay in CC", resval: "5000000"}
      ]
    },
    {
      name: "Modes"
      desc: "Controls the Mode of the Running Light"
      swaccess: "rw"
      hwaccess: "hro"
      fields: [
        {bits: "1:0", name: "Mode", desc: "00 - Stop, 01 - Rotate Right, 10 - Rotate Left, 11 - PingPong", resval: "0x3"}
      ]
    },
    {
      name: "LED_Status"
      desc: "Currently active LEDs"
      swaccess: "ro"
      hwaccess: "hwo"
      fields: [
        {bits: "7:0", name: "led_status", desc: "bit pattern"}
      ]
    }
  ]
}
