{
  name: "irq_ctrl"
  clock_primary: "sys_clk"
  bus_device: "tlul"
  regwidth: "32"
  registers: [
    {
      name: "all_en"
      desc: "0: suppresses all outgoing interrupt requests, 1: allows outgoing interrupt requests"
      swaccess: "rw"
      hwaccess: "hro"
      #hwext: "true"
      fields: [
        {bits: "0", name: "all_en", desc: "value"}
      ]
    }
    {
      name: "mask"
      desc: "mask(n) = 1 <=> irq(n) enabled"
      swaccess: "rw"
      hwaccess: "hro"
      fields: [
        {bits: "31:0", name: "mask", desc: "value"}
      ]
    }
    {
      name: "mask_set"
      desc: "mask_set(n) = 1 <=> set bit n in mask"
      swaccess: "rw1s"
      hwaccess: "hro"
      fields:
      [
        {bits: "31:0", name: "mask_set", desc: "1 = unmasked, 0 = masked"}
      ]
    }
	{
	 name: "mask_clr"
	 desc: "mask_clr(n) = 1 <=> clear bit n in mask"
	 swaccess: "rw1c"
	 hwaccess: "hro"
	 fields:
	 [
		{bits: "31:0", name: "mask_clr", desc: "1 = clear bit n in mask to 0"}
	 ] 
	}
	{
	 name: "status"
	 desc: "monitor the state of all interrupt lines"
	 swaccess: "ro"
	 hwaccess: "hwo"
	 fields:
	 [
		{bits: "31:0", name: "status", desc: "status(n) = 1 <=> irq(n) is asserted "}
	 ] 
	}
	{
	 name: "irq_no"
	 desc: "indicate the number (or index) of the currently active highest-priority (lowest index: highest priority) interrupt that is unmasked, If there is no active and unmasked interrupt, irq_no is set to IRQ_MAX"
	 swaccess: "ro"
	 hwaccess: "hwo"
	 fields:
	 [
		{bits: "31:0", name: "irq_no", desc: "n < IRQ_MAX: irq_no = n, irq(n) = 1 and there is no m < n with irq(m) = 1 and mask(m) = 1. n = IRQ_MAX: no pending unmasked irq"}
	 ] 
	}
	{
	 name: "test"
	 desc: "choose between test and regular operation mode"
	 swaccess: "rw"
	 hwaccess: "hro"
	 fields:
	 [
		{bits: "0", name: "test", desc: "0: regular operation; 1: all irq inputs are wired to the test_irq register"}
	 ] 
	}
	{
	 name: "test_irq"
	 desc: "32 bit test register to stimulate the interrupt lines"
	 swaccess: "rw"
	 hwaccess: "hro"
	 fields:
	 [
		{bits: "31:0", name: "test_irq", desc: "simulating irq lines"}
	 ] 
	}
  ]
}
