{
  name: "student_iis_handler"
  clock_primary: "sys_clk"
  bus_device: "tlul"
  regwidth: "32"
  registers: [
    {
      name: "serial_in"
      desc: "send Serial Bits into IIS Handler"
      swaccess: "wo"
      hwaccess: "hro"
      hwqe : "true"
      fields: [
        {bits: "15:0", name: "IIS_S_IN", desc: "send Serial Bits into IIS Handler"}
      ]
    }
	{
      name: "serial_out"
      desc: "read Serial Bits out from IIS Handler"
      swaccess: "ro"
      hwaccess: "hwo"
      fields: [
        {bits: "31:0", name: "IIS_S_OUT", desc: "read Serial Bits out from IIS Handler"}
      ]
    }
	{
      name: "pcm_out"
      desc: "read PCM Bits which are sent to fir"
      swaccess: "ro"
      hwaccess: "hwo"
      fields: [
        {bits: "15:0", name: "iis_to_fir", desc: "send PCM Bits in IIS Handler"}
      ]
    }
	{
      name: "pcm_in"
      desc: "send PCM Bits which would come from fir"
      swaccess: "wo"
      hwaccess: "hro"
      hwqe : "true"
      fields: [
        {bits: "31:0", name: "fir_to_iis", desc: "read PCM Bits out of IIS Handler"}
      ]
    }
  ]
}