{
  name: "student_iis_handler"
  clock_primary: "sys_clk"
  bus_device: "tlul"
  regwidth: "32"
  registers: [
    {
      name: "IIS_Serial_In"
      desc: "send Serial Bits into IIS Handler"
      swaccess: "wo"
      hwaccess: "hro"
      hwext: "true"
      fields: [
        {bits: "0", name: "IIS_S_IN", desc: "send Serial Bits into IIS Handler"}
      ]
    }
	{
      name: "IIS_Serial_Out"
      desc: "read Serial Bits out from IIS Handler"
      swaccess: "ro"
      hwaccess: "hwo"
      hwext: "true"
      fields: [
        {bits: "0", name: "IIS_S_OUT", desc: "read Serial Bits out from IIS Handler"}
      ]
    }
	{
      name: "IIS_Parallel_CODEC2HW"
      desc: "send PCM Bits in IIS Handler"
      swaccess: "wo"
      hwaccess: "hro"
      hwext: "true"
      fields: [
        {bits: "31:0", name: "IIS_P_IN", desc: "send PCM Bits in IIS Handler"}
      ]
    }
	{
      name: "IIS_Parallel_HW2CODEC"
      desc: "read PCM Bits out of IIS Handler"
      swaccess: "ro"
      hwaccess: "hwo"
      hwext: "true"
      fields: [
        {bits: "31:0", name: "IIS_P_OUT", desc: "read PCM Bits out of IIS Handler"}
      ]
    }
	
	
  ]
}